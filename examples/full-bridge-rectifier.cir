Full Bridge Rectifier
* OpenSpice layout v1 (wide_transformer_windings:true,full_center_tapped_secondary:true,rotations:{"X1":3,"X5":0,"X3":3,"I1":1,"V1":1,"C1":1,"X2":3,"X4":3},positions:{"X5":(-8,9),"I1":(15,5),"X4":(3,8),"X2":(3,2),"X1":(-2,2),"X3":(-2,8),"C1":(9,5),"V1":(-13,9)},wires:[((-13,7),(-10,7)),((-13,11),(-10,11)),((-6,5),(-6,7)),((-6,5),(-2,5)),((-6,11),(-6,13)),((-6,13),(1,13)),((-2,-1),(-2,0)),((-2,-1),(3,-1)),((-2,4),(-2,5)),((-2,5),(-2,6)),((-2,10),(-2,11)),((-2,11),(3,11)),((1,5),(1,13)),((1,5),(3,5)),((3,-1),(3,0)),((3,-1),(9,-1)),((3,4),(3,5)),((3,5),(3,6)),((3,10),(3,11)),((3,11),(6,11)),((6,11),(6,12)),((6,11),(9,11)),((9,-1),(9,3)),((9,-1),(15,-1)),((9,7),(9,11)),((9,11),(15,11)),((15,-1),(15,3)),((15,7),(15,11))],grounds:[(6,12)],powers:[],labels:{"X2":Hidden,"X1":Hidden,"X5":Offset(-39.3125,-67.0),"X3":Hidden,"X4":Hidden,"V1":Offset(-35.0,-15.0)})
I1 n2 0 1m
C1 n2 0 1m
V1 n6 n8 SIN(0 230 50 0 0 0)
X5 n6 n8 n3 n5 os_xfmr ratio=1
X4 0 n5 os_diode_piecewise
X3 0 n3 os_diode_piecewise
X2 n5 n2 os_diode_piecewise
X1 n3 n2 os_diode_piecewise
.subckt os_diode_piecewise a k params: vf=0.7 ron=0.01 roff=1e9 bv=0
B1 a k I={V(a,k)/roff + (1/ron-1/roff)*(max(V(a,k)-vf,0)-ternary_fcn(bv>0,max(-V(a,k)-bv,0),0))}
.ends
.tran 5u 1
.subckt os_diode_standard a k
D1 a k md
.model md D
.ends
.subckt os_diode a k
D1 a k md
.model md D
.ends
.subckt os_rectifier a k
D1 a k md
.model md D(IS=7n N=1.8 RS=0.04 CJO=25p TT=2u BV=100 IBV=10u)
.ends
.subckt os_schottky a k
D1 a k md
.model md D(IS=2u N=1.05 RS=0.08 CJO=80p BV=40 IBV=1m)
.ends
.subckt os_zener a k
D1 a k md
.model md D(IS=1p N=1.2 RS=2 CJO=80p BV=5.1 IBV=1m)
.ends
.subckt os_xfmr p1 p2 s1 s2 params: ratio=1
Esecondary s1 s2 p1 p2 {ratio}
Fprimary p1 p2 Esecondary {-ratio}
.ends
.end
